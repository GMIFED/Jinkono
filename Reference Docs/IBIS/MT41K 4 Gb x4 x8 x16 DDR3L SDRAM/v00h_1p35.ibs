| v00h_1p35.ibs * IBIS 4.2 Model
| 4Gb DDR3L SDRAM - Die Revision "P"
| This Model is valid for Commercial Temperature Range 0C<=Tc<=95C
| Valid for DDR3-1066/1333/1600/1866 operation
| Models *_1066 are applicable for speed grade 1066 Mbps
| Models *_1600 are applicable for speed grade 1333/1600 Mbps
| Models *_1866 are applicable for speed grade 1866 Mbps
| Models *_2133 are applicable for speed grade 2133 Mbps
| Part Number   VDD/VDDQ   Architecture   Package
| MT41K1G4DA   1.35V/1.35V   1Gig x  4   78-Ball 8x10.5mm FBGA
| MT41K512M8DA   1.35V/1.35V   512Meg x  8   78-Ball 8x10.5mm FBGA
| MT41K256M16TW   1.35V/1.35V   256Meg x 16   96-Ball 8x14mm FBGA
| MT41K1G4V00H   1.35V/1.35V   1Gig x  4   Bare Die
| MT41K512M8V00H   1.35V/1.35V   512Meg x  8   Bare Die
| MT41K256M16V00H   1.35V/1.35V   256Meg x 16   Bare Die
[IBIS Ver]   4.2
[File Name]   v00h_1p35.ibs
[Date]   08/13/2019
[File Rev]   2.0.1
[Source]   From silicon level SPICE model at Micron Technology, Inc.
   For support e-mail modelsupport@micron.com
[Notes]   Revision History:
   Rev 1.0: 07/17/2014
   - Initial pre-silicon model
   - Model data extracted from HSpice model revision 1.0
   Rev 2.0: 08/25/2015
   - Matched C_comp to latest measurements
   - Matched I-V curves to latest measurements
   - Model data extracted from HSpice model revision 2.0
   Rev 2.0.1: 08/13/2019
   - Added Package Model keyword to Component sections
   Notes:
   - This IBIS file uses the Submodel keyword to model the
   DDR3 On-die Termination (ODT) characteristics.
   - The C_comp value in the DQ model is set to match the input
   state of the DQ I/O as measured from the HSPICE model.
   Due to the C_comp differences between the DQ model and the
   DQ_ODT* models, the output characteristics of the
   models will look different when simulated. To match most
   closely with the HSPICE model, simulate with the DQ_34
   or DQ_40 model for ALL Output simulations.  Use the ODT
   models ONLY for Input simulations.
   - INPUT1_* is applicable to: A0 - A9, A12 - A15
   - INPUT2_* is applicable to: BA0-BA2, CAS, CS#, CKE, A10, ODT,
   RAS, WE
   - All Submodels: when running through ibischk4.2, this file
   contains warnings about GND and Power Clamp data being
   non-monotonic. When Submodel I-V curves are added to
   non-odt Power and GND Clamp curves, the resultant
   curve is monotonic. This is not checked correctly with the
   IBIS parser.
   - L_pin values in the Pin sections are loop inductance and
   include the mutual inductance to appropriate POWER/GND
   return paths.  POWER/GND parasitics are modeled in the
   Package Models.
   - Typ and slow corner V-t curves in the following DQ* models
   are shifted relative to strong corner V-t curve
   to contain all 3 corners within appropriate V-t window
   Models   Typ   Slow   V-t duration
   DQ_34*_1066   -210ps   -620ps   625ps
   DQ_40*_1066   -210ps   -620ps   625ps
   DQ_34*_1600   -210ps   -620ps   625ps
   DQ_40*_1600   -210ps   -620ps   625ps
   DQ_34*_1866   -210ps   -646ps   555ps
   DQ_40*_1866   -210ps   -646ps   555ps
   DQ_34*_2133   -150ps   -370ps   468ps
   DQ_40*_2133   -150ps   -370ps   468ps
   - Due to the shift in typ and slow corner, the V-t curves
   may overlap each other. This does not effect the accuracy
   of the IBIS data.
   - For *_2133 models min (slow) corner uses typical process
   models and typ corner uses adjusted fast process models.
   - The following models required overclocking (see Quality
   Report for details): DQ_*_1866, DQS_*_1866
   - When running through ibischk4.2.1 or older parsers, this
   file will contain errors related to the Differential
   Receiver Thresholds. These errors can be fixed by
   removing comment characters '|' in DQS_* and CLKIN_* models
   in front of Single-ended Receiver Thresholds parameters and
   removing the Differential Receiver Thresholds parameters.
   - The NF_INPUT Model is for Non-functioning DQs in the x4
   package
   - IBIS Quality Specification 2.0 Summary:
   IQ Score: IQ3MS
   See Micron IBIS Model Quality Report and Quality Checklist
   for full IQ details
[Disclaimer]  This software code and all associated documentation, comments
              or other information (collectively "Software") is provided
              "AS IS" without warranty of any kind. MICRON TECHNOLOGY, INC.
              ("MTI") EXPRESSLY DISCLAIMS ALL WARRANTIES EXPRESS OR IMPLIED,
              INCLUDING BUT NOT LIMITED TO, NONINFRINGEMENT OF THIRD PARTY
              RIGHTS, AND ANY IMPLIED WARRANTIES OF MERCHANTABILITY OR
              FITNESS FOR ANY PARTICULAR PURPOSE. MTI DOES NOT WARRANT THAT
              THE SOFTWARE WILL MEET YOUR REQUIREMENTS, OR THAT THE
              OPERATION OF THE SOFTWARE WILL BE UNINTERRUPTED OR ERROR-FREE.
              FURTHERMORE, MTI DOES NOT MAKE ANY REPRESENTATIONS REGARDING
              THE USE OR THE RESULTS OF THE USE OF THE SOFTWARE IN TERMS OF
              ITS CORRECTNESS, ACCURACY, RELIABILITY, OR OTHERWISE. THE
              ENTIRE RISK ARISING OUT OF USE OR PERFORMANCE OF THE SOFTWARE
              REMAINS WITH YOU. IN NO EVENT SHALL MTI, ITS AFFILIATED
              COMPANIES OR THEIR SUPPLIERS BE LIABLE FOR ANY DIRECT,
              INDIRECT, CONSEQUENTIAL, INCIDENTAL, OR SPECIAL DAMAGES
              (INCLUDING, WITHOUT LIMITATION, DAMAGES FOR LOSS OF PROFITS,
              BUSINESS INTERRUPTION, OR LOSS OF INFORMATION) ARISING OUT OF
              YOUR USE OF OR INABILITY TO USE THE SOFTWARE, EVEN IF MTI HAS
              BEEN ADVISED OF THE POSSIBILITY OF SUCH DAMAGES. Because some
              jurisdictions prohibit the exclusion or limitation of
              liability for consequential or incidental damages, the above
              limitation may not apply to you.
[Copyright]   Copyright 2015 Micron Technology, Inc. All rights reserved.
| COMPONENT: MT41K1G4DA (78-Ball FBGA, x4, 8mm X 10.5mm)
[Component]   MT41K1G4DA
[Package Model] v00h_78ball_pkg
[Manufacturer]  Micron Technology,Inc.
[Package]
|   typ   min   max
R_pkg   325.78m   226.98m   429.67m
L_pkg   1.97nH   1.19nH   2.94nH
C_pkg   0.45pF   0.38pF   0.59pF
[Pin]   signal_name model_name   R_pin   L_pin   C_pin
A1   VSS   GND
A2   VDD   POWER
A3   NC   NC
A7   NF   NF_INPUT   350.02m   1.80nH   0.51pF
A8   VSS   GND
A9   VDD   POWER
B1   VSS   GND
B2   VSSQ   GND
B3   DQ0   DQ   302.45m   1.60nH   0.46pF
B7   DM   DM   352.57m   1.75nH   0.51pF
B8   VSSQ   GND
B9   VDDQ   POWER
C1   VDDQ   POWER
C2   DQ2   DQ   367.63m   1.93nH   0.55pF
C3   DQS   DQS   294.99m   1.66nH   0.45pF
C7   DQ1   DQ   280.95m   1.37nH   0.50pF
C8   DQ3   DQ   374.98m   1.83nH   0.57pF
C9   VSSQ   GND
D1   VSSQ   GND
D2   NF   NF_INPUT   309.87m   1.68nH   0.45pF
D3   DQS#   DQS   296.80m   1.63nH   0.42pF
D7   VDD   POWER
D8   VSS   GND
D9   VSSQ   GND
E1   VREFDQ   POWER
E2   VDDQ   POWER
E3   NF   NF_INPUT   230.15m   1.19nH   0.42pF
E7   NF   NF_INPUT   226.98m   1.21nH   0.41pF
E8   NF   NF_INPUT   311.29m   1.52nH   0.48pF
E9   VDDQ   POWER
F1   NC   NC
F2   VSS   GND
F3   RAS#   INPUT2   285.32m   1.67nH   0.39pF
F7   CK   CLKIN   275.62m   1.66nH   0.42pF
F8   VSS   GND
F9   NC   NC
G1   ODT   INPUT1   330.65m   2.40nH   0.43pF
G2   VDD   POWER
G3   CAS#   INPUT2   286.10m   1.87nH   0.37pF
G7   CK#   CLKIN   275.07m   1.71nH   0.39pF
G8   VDD   POWER
G9   CKE   INPUT1   337.46m   2.31nH   0.41pF
H1   NC   NC
H2   CS#   INPUT2   252.93m   1.82nH   0.41pF
H3   WE#   INPUT2   292.87m   1.82nH   0.36pF
H7   A10   INPUT2   294.33m   1.73nH   0.35pF
H8   ZQ   NC
H9   NC   NC
J1   VSS   GND
J2   BA0   INPUT1   285.53m   1.82nH   0.39pF
J3   BA2   INPUT1   314.12m   1.82nH   0.38pF
J7   A15   INPUT1   313.78m   1.68nH   0.39pF
J8   VREFCA   POWER
J9   VSS   GND
K1   VDD   POWER
K2   A3   INPUT1   304.87m   1.94nH   0.40pF
K3   A0   INPUT2   327.44m   2.10nH   0.38pF
K7   A12   INPUT2   322.37m   2.05nH   0.39pF
K8   BA1   INPUT1   292.48m   1.91nH   0.41pF
K9   VDD   POWER
L1   VSS   GND
L2   A5   INPUT1   340.25m   2.30nH   0.46pF
L3   A2   INPUT1   361.19m   2.38nH   0.44pF
L7   A1   INPUT1   359.81m   2.39nH   0.46pF
L8   A4   INPUT1   340.23m   2.29nH   0.47pF
L9   VSS   GND
M1   VDD   POWER
M2   A7   INPUT1   377.31m   2.61nH   0.51pF
M3   A9   INPUT1   397.49m   2.69nH   0.51pF
M7   A11   INPUT1   405.72m   2.52nH   0.51pF
M8   A6   INPUT1   383.66m   2.50nH   0.52pF
M9   VDD   POWER
N1   VSS   GND
N2   RST#   RESET   415.60m   2.94nH   0.55pF
N3   A13   INPUT1   358.72m   2.04nH   0.53pF
N7   A14   INPUT1   371.91m   2.20nH   0.56pF
N8   A8   INPUT1   429.67m   2.62nH   0.59pF
N9   VSS   GND
|***********************PIN MAPPING*****************************************
[Pin Mapping] pulldown_ref pullup_ref gnd_clamp_ref power_clamp_ref ext_ref
A1   VSS   NC
A2   NC   VDD
A3   NC   NC
A7   NC   NC
A8   VSS   NC
A9   NC   VDD
B1   VSS   NC
B2   VSS   NC
B3   VSS   VDDQ   VSS   VDDQ
B7   NC   NC   VSS   VDDQ
B8   VSS   NC
B9   NC   VDDQ
C1   NC   VDDQ
C2   VSS   VDDQ   VSS   VDDQ
C3   VSS   VDDQ   VSS   VDDQ
C7   VSS   VDDQ   VSS   VDDQ
C8   VSS   VDDQ   VSS   VDDQ
C9   VSS   NC
D1   VSS   NC
D2   NC   NC
D3   VSS   VDDQ   VSS   VDDQ
D7   NC   VDD
D8   VSS   NC
D9   VSS   NC
E1   NC   VREFDQ
E2   NC   VDDQ
E3   NC   NC
E7   NC   NC
E8   NC   NC
E9   NC   VDDQ
F1   NC   NC
F2   VSSL   NC
F3   NC   NC   VSS   VDD
F7   NC   NC   VSS   VDD
F8   VSS   NC
F9   NC   NC
G1   NC   NC   VSS   VDD
G2   NC   VDDL
G3   NC   NC   VSS   VDD
G7   NC   NC   VSS   VDD
G8   NC   VDD
G9   NC   NC   VSS   VDD
H1   NC   NC
H2   NC   NC   VSS   VDD
H3   NC   NC   VSS   VDD
H7   NC   NC   VSS   VDD
H8   NC   NC
H9   NC   NC
J1   VSS   NC
J2   NC   NC   VSS   VDD
J3   NC   NC   VSS   VDD
J7   NC   NC   VSS   VDD
J8   NC   VREFCA
J9   VSS   NC
K1   NC   VDD
K2   NC   NC   VSS   VDD
K3   NC   NC   VSS   VDD
K7   NC   NC   VSS   VDD
K8   NC   NC   VSS   VDD
K9   NC   VDD
L1   VSS   NC
L2   NC   NC   VSS   VDD
L3   NC   NC   VSS   VDD
L7   NC   NC   VSS   VDD
L8   NC   NC   VSS   VDD
L9   VSS   NC
M1   NC   VDD
M2   NC   NC   VSS   VDD
M3   NC   NC   VSS   VDD
M7   NC   NC   VSS   VDD
M8   NC   NC   VSS   VDD
M9   NC   VDD
N1   VSS   NC
N2   NC   NC   VSS   VDD
N3   NC   NC   VSS   VDD
N7   NC   NC   VSS   VDD
N8   NC   NC   VSS   VDD
N9   VSS   NC
|**********************DIFF PIN*********************************************
[Diff_pin]   inv_pin   vdiff   tdelay_typ   tdelay_min   tdelay_max
   C3   D3   0.320V   0ns   NA   NA
   F7   G7   0.320V   0ns   NA   NA
| COMPONENT: MT41K512M8DA (78-Ball FBGA, x8, 8mm X 10.5mm)
[Component]   MT41K512M8DA
[Package Model] v00h_78ball_pkg
[Manufacturer]  Micron Technology,Inc.
[Package]
|   typ   min   max
R_pkg   325.78m   226.98m   429.67m
L_pkg   1.97nH   1.19nH   2.94nH
C_pkg   0.45pF   0.38pF   0.59pF
[Pin]   signal_name model_name   R_pin   L_pin   C_pin
A1   VSS   GND
A2   VDD   POWER
A3   NC   NC
A7   NF_TDQS#   NF_TDQS#   350.02m   1.80nH   0.51pF
A8   VSS   GND
A9   VDD   POWER
B1   VSS   GND
B2   VSSQ   GND
B3   DQ0   DQ   302.45m   1.60nH   0.46pF
B7   DM_TDQS   DM_TDQS   352.57m   1.75nH   0.51pF
B8   VSSQ   GND
B9   VDDQ   POWER
C1   VDDQ   POWER
C2   DQ2   DQ   367.63m   1.93nH   0.55pF
C3   DQS   DQS   294.99m   1.66nH   0.45pF
C7   DQ1   DQ   280.95m   1.37nH   0.50pF
C8   DQ3   DQ   374.98m   1.83nH   0.57pF
C9   VSSQ   GND
D1   VSSQ   GND
D2   DQ6   DQ   309.87m   1.68nH   0.45pF
D3   DQS#   DQS   296.80m   1.63nH   0.42pF
D7   VDD   POWER
D8   VSS   GND
D9   VSSQ   GND
E1   VREFDQ   POWER
E2   VDDQ   POWER
E3   DQ4   DQ   230.15m   1.19nH   0.42pF
E7   DQ7   DQ   226.98m   1.21nH   0.41pF
E8   DQ5   DQ   311.29m   1.52nH   0.48pF
E9   VDDQ   POWER
F1   NC   NC
F2   VSS   GND
F3   RAS#   INPUT2   285.32m   1.67nH   0.39pF
F7   CK   CLKIN   275.62m   1.66nH   0.42pF
F8   VSS   GND
F9   NC   NC
G1   ODT   INPUT1   330.65m   2.40nH   0.43pF
G2   VDD   POWER
G3   CAS#   INPUT2   286.10m   1.87nH   0.37pF
G7   CK#   CLKIN   275.07m   1.71nH   0.39pF
G8   VDD   POWER
G9   CKE   INPUT1   337.46m   2.31nH   0.41pF
H1   NC   NC
H2   CS#   INPUT2   252.93m   1.82nH   0.41pF
H3   WE#   INPUT2   292.87m   1.82nH   0.36pF
H7   A10   INPUT2   294.33m   1.73nH   0.35pF
H8   ZQ   NC
H9   NC   NC
J1   VSS   GND
J2   BA0   INPUT1   285.53m   1.82nH   0.39pF
J3   BA2   INPUT1   314.12m   1.82nH   0.38pF
J7   A15   INPUT1   313.78m   1.68nH   0.39pF
J8   VREFCA   POWER
J9   VSS   GND
K1   VDD   POWER
K2   A3   INPUT1   304.87m   1.94nH   0.40pF
K3   A0   INPUT2   327.44m   2.10nH   0.38pF
K7   A12   INPUT2   322.37m   2.05nH   0.39pF
K8   BA1   INPUT1   292.48m   1.91nH   0.41pF
K9   VDD   POWER
L1   VSS   GND
L2   A5   INPUT1   340.25m   2.30nH   0.46pF
L3   A2   INPUT1   361.19m   2.38nH   0.44pF
L7   A1   INPUT1   359.81m   2.39nH   0.46pF
L8   A4   INPUT1   340.23m   2.29nH   0.47pF
L9   VSS   GND
M1   VDD   POWER
M2   A7   INPUT1   377.31m   2.61nH   0.51pF
M3   A9   INPUT1   397.49m   2.69nH   0.51pF
M7   A11   INPUT1   405.72m   2.52nH   0.51pF
M8   A6   INPUT1   383.66m   2.50nH   0.52pF
M9   VDD   POWER
N1   VSS   GND
N2   RST#   RESET   415.60m   2.94nH   0.55pF
N3   A13   INPUT1   358.72m   2.04nH   0.53pF
N7   A14   INPUT1   371.91m   2.20nH   0.56pF
N8   A8   INPUT1   429.67m   2.62nH   0.59pF
N9   VSS   GND
|***********************PIN MAPPING*****************************************
[Pin Mapping] pulldown_ref pullup_ref gnd_clamp_ref power_clamp_ref ext_ref
A1   VSS   NC
A2   NC   VDD
A3   NC   NC
A7   VSS   VDDQ   VSS   VDDQ
A8   VSS   NC
A9   NC   VDD
B1   VSS   NC
B2   VSS   NC
B3   VSS   VDDQ   VSS   VDDQ
B7   VSS   VDDQ   VSS   VDDQ
B8   VSS   NC
B9   NC   VDDQ
C1   NC   VDDQ
C2   VSS   VDDQ   VSS   VDDQ
C3   VSS   VDDQ   VSS   VDDQ
C7   VSS   VDDQ   VSS   VDDQ
C8   VSS   VDDQ   VSS   VDDQ
C9   VSS   NC
D1   VSS   NC
D2   VSS   VDDQ   VSS   VDDQ
D3   VSS   VDDQ   VSS   VDDQ
D7   NC   VDD
D8   VSS   NC
D9   VSS   NC
E1   NC   VREFDQ
E2   NC   VDDQ
E3   VSS   VDDQ   VSS   VDDQ
E7   VSS   VDDQ   VSS   VDDQ
E8   VSS   VDDQ   VSS   VDDQ
E9   NC   VDDQ
F1   NC   NC
F2   VSSL   NC
F3   NC   NC   VSS   VDD
F7   NC   NC   VSS   VDD
F8   VSS   NC
F9   NC   NC
G1   NC   NC   VSS   VDD
G2   NC   VDDL
G3   NC   NC   VSS   VDD
G7   NC   NC   VSS   VDD
G8   NC   VDD
G9   NC   NC   VSS   VDD
H1   NC   NC
H2   NC   NC   VSS   VDD
H3   NC   NC   VSS   VDD
H7   NC   NC   VSS   VDD
H8   NC   NC
H9   NC   NC
J1   VSS   NC
J2   NC   NC   VSS   VDD
J3   NC   NC   VSS   VDD
J7   NC   NC   VSS   VDD
J8   NC   VREFCA
J9   VSS   NC
K1   NC   VDD
K2   NC   NC   VSS   VDD
K3   NC   NC   VSS   VDD
K7   NC   NC   VSS   VDD
K8   NC   NC   VSS   VDD
K9   NC   VDD
L1   VSS   NC
L2   NC   NC   VSS   VDD
L3   NC   NC   VSS   VDD
L7   NC   NC   VSS   VDD
L8   NC   NC   VSS   VDD
L9   VSS   NC
M1   NC   VDD
M2   NC   NC   VSS   VDD
M3   NC   NC   VSS   VDD
M7   NC   NC   VSS   VDD
M8   NC   NC   VSS   VDD
M9   NC   VDD
N1   VSS   NC
N2   NC   NC   VSS   VDD
N3   NC   NC   VSS   VDD
N7   NC   NC   VSS   VDD
N8   NC   NC   VSS   VDD
N9   VSS   NC
|**********************DIFF PIN*********************************************
[Diff_pin]   inv_pin   vdiff   tdelay_typ   tdelay_min   tdelay_max
   C3   D3   0.320V   0ns   NA   NA
   F7   G7   0.320V   0ns   NA   NA
| COMPONENT: MT41K256M16TW (96-Ball FBGA, x16, 8mm X 14mm)
[Component]   MT41K256M16TW
[Package Model] v00h_96ball_pkg
[Manufacturer]  Micron Technology,Inc.
[Package]
|   typ   min   max
R_pkg   356.04m   224.03m   506.70m
L_pkg   2.17nH   1.08nH   3.54nH
C_pkg   0.51pF   0.39pF   0.66pF
[Pin]   signal_name model_name   R_pin   L_pin   C_pin
A1   VDDQ   POWER
A2   DQ13   DQ   407.65m   2.19nH   0.61pF
A3   DQ15   DQ   349.46m   1.81nH   0.54pF
A7   DQ12   DQ   340.14m   1.71nH   0.52pF
A8   VDDQ   POWER
A9   VSS   GND
B1   VSSQ   GND
B2   VDD   POWER
B3   VSS   GND
B7   UDQS#   DQS   327.79m   1.84nH   0.50pF
B8   DQ14   DQ   411.24m   1.99nH   0.60pF
B9   VSSQ   GND
C1   VDDQ   POWER
C2   DQ11   DQ   373.04m   1.75nH   0.53pF
C3   DQ9   DQ   300.71m   1.47nH   0.47pF
C7   UDQS   DQS   328.94m   1.82nH   0.47pF
C8   DQ10   DQ   363.20m   1.81nH   0.50pF
C9   VDDQ   POWER
D1   VSSQ   GND
D2   VDDQ   POWER
D3   UDM   DM   273.39m   1.42nH   0.46pF
D7   DQ8   DQ   261.09m   1.27nH   0.45pF
D8   VSSQ   GND
D9   VDD   POWER
E1   VSS   GND
E2   VSSQ   GND
E3   DQ0   DQ   228.97m   1.08nH   0.42pF
E7   LDM   DM   224.03m   1.14nH   0.43pF
E8   VSSQ   GND
E9   VDDQ   POWER
F1   VDDQ   POWER
F2   DQ2   DQ   292.38m   1.44nH   0.45pF
F3   LDQS   DQS   224.44m   1.23nH   0.39pF
F7   DQ1   DQ   278.30m   1.31nH   0.43pF
F8   DQ3   DQ   294.77m   1.37nH   0.47pF
F9   VSSQ   GND
G1   VSSQ   GND
G2   DQ6   DQ   273.36m   1.37nH   0.41pF
G3   LDQS#   DQS   226.71m   1.24nH   0.39pF
G7   VDD   POWER
G8   VSS   GND
G9   VSSQ   GND
H1   VREFDQ   POWER
H2   VDDQ   POWER
H3   DQ4   DQ   308.85m   1.52nH   0.40pF
H7   DQ7   DQ   308.13m   1.54nH   0.41pF
H8   DQ5   DQ   275.48m   1.34nH   0.43pF
H9   VDDQ   POWER
J1   NC   NC
J2   VSS   GND
J3   RAS#   INPUT2   286.24m   1.73nH   0.41pF
J7   CK   CLKIN   285.39m   1.70nH   0.40pF
J8   VSS   GND
J9   NC   NC
K1   ODT   INPUT1   386.27m   2.64nH   0.51pF
K2   VDD   POWER
K3   CAS#   INPUT2   289.91m   1.85nH   0.40pF
K7   CK#   CLKIN   286.00m   1.76nH   0.46pF
K8   VDD   POWER
K9   CKE   INPUT1   387.91m   2.63nH   0.49pF
L1   NC   NC
L2   CS#   INPUT2   336.42m   2.25nH   0.45pF
L3   WE#   INPUT2   291.30m   1.93nH   0.45pF
L7   A10   INPUT2   288.14m   1.93nH   0.44pF
L8   ZQ   NC
L9   NC   NC
M1   VSS   GND
M2   BA0   INPUT1   367.10m   2.38nH   0.50pF
M3   BA2   INPUT1   382.02m   2.26nH   0.50pF
M7   NC   NC   380.74m   2.57nH   0.48pF
M8   VREFCA   POWER
M9   VSS   GND
N1   VDD   POWER
N2   A3   INPUT1   401.42m   2.29nH   0.57pF
N3   A0   INPUT2   416.81m   2.63nH   0.52pF
N7   A12   INPUT2   416.81m   2.90nH   0.52pF
N8   BA1   INPUT1   393.02m   2.82nH   0.54pF
N9   VDD   POWER
P1   VSS   GND
P2   A5   INPUT1   430.95m   2.96nH   0.58pF
P3   A2   INPUT1   440.61m   3.02nH   0.56pF
P7   A1   INPUT1   453.49m   3.20nH   0.58pF
P8   A4   INPUT1   431.32m   3.16nH   0.59pF
P9   VSS   GND
R1   VDD   POWER
R2   A7   INPUT1   469.49m   3.40nH   0.62pF
R3   A9   INPUT1   469.04m   3.24nH   0.61pF
R7   A11   INPUT1   488.56m   3.35nH   0.63pF
R8   A6   INPUT1   466.30m   3.35nH   0.65pF
R9   VDD   POWER
T1   VSS   GND
T2   RST#   RESET   492.95m   3.54nH   0.66pF
T3   A13   INPUT1   435.72m   3.10nH   0.59pF
T7   A14   INPUT1   449.12m   2.74nH   0.63pF
T8   A8   INPUT1   506.70m   3.46nH   0.66pF
T9   VSS   GND
|***********************PIN MAPPING*****************************************
[Pin Mapping] pulldown_ref pullup_ref gnd_clamp_ref power_clamp_ref ext_ref
A1   NC   VDDQ
A2   VSS   VDDQ   VSS   VDDQ
A3   VSS   VDDQ   VSS   VDDQ
A7   VSS   VDDQ   VSS   VDDQ
A8   NC   VDDQ
A9   VSS   NC
B1   VSS   NC
B2   NC   VDD
B3   VSS   NC
B7   VSS   VDDQ   VSS   VDDQ
B8   VSS   VDDQ   VSS   VDDQ
B9   VSS   NC
C1   NC   VDDQ
C2   VSS   VDDQ   VSS   VDDQ
C3   VSS   VDDQ   VSS   VDDQ
C7   VSS   VDDQ   VSS   VDDQ
C8   VSS   VDDQ   VSS   VDDQ
C9   NC   VDDQ
D1   VSS   NC
D2   NC   VDDQ
D3   NC   NC   VSS   VDDQ
D7   VSS   VDDQ   VSS   VDDQ
D8   VSS   NC
D9   NC   VDD
E1   VSS   NC
E2   VSS   NC
E3   VSS   VDDQ   VSS   VDDQ
E7   NC   NC   VSS   VDDQ
E8   VSS   NC
E9   NC   VDDQ
F1   NC   VDDQ
F2   VSS   VDDQ   VSS   VDDQ
F3   VSS   VDDQ   VSS   VDDQ
F7   VSS   VDDQ   VSS   VDDQ
F8   VSS   VDDQ   VSS   VDDQ
F9   VSS   NC
G1   VSS   NC
G2   VSS   VDDQ   VSS   VDDQ
G3   VSS   VDDQ   VSS   VDDQ
G7   NC   VDD
G8   VSS   NC
G9   VSS   NC
H1   NC   VREFDQ
H2   NC   VDDQ
H3   VSS   VDDQ   VSS   VDDQ
H7   VSS   VDDQ   VSS   VDDQ
H8   VSS   VDDQ   VSS   VDDQ
H9   NC   VDDQ
J1   NC   NC
J2   VSSL   NC
J3   NC   NC   VSS   VDD
J7   NC   NC   VSS   VDD
J8   VSS   NC
J9   NC   NC
K1   NC   NC   VSS   VDD
K2   NC   VDDL
K3   NC   NC   VSS   VDD
K7   NC   NC   VSS   VDD
K8   NC   VDD
K9   NC   NC   VSS   VDD
L1   NC   NC
L2   NC   NC   VSS   VDD
L3   NC   NC   VSS   VDD
L7   NC   NC   VSS   VDD
L8   NC   NC
L9   NC   NC
M1   VSS   NC
M2   NC   NC   VSS   VDD
M3   NC   NC   VSS   VDD
M7   NC   NC
M8   NC   VREFCA
M9   VSS   NC
N1   NC   VDD
N2   NC   NC   VSS   VDD
N3   NC   NC   VSS   VDD
N7   NC   NC   VSS   VDD
N8   NC   NC   VSS   VDD
N9   NC   VDD
P1   VSS   NC
P2   NC   NC   VSS   VDD
P3   NC   NC   VSS   VDD
P7   NC   NC   VSS   VDD
P8   NC   NC   VSS   VDD
P9   VSS   NC
R1   NC   VDD
R2   NC   NC   VSS   VDD
R3   NC   NC   VSS   VDD
R7   NC   NC   VSS   VDD
R8   NC   NC   VSS   VDD
R9   NC   VDD
T1   VSS   NC
T2   NC   NC   VSS   VDD
T3   NC   NC   VSS   VDD
T7   NC   NC   VSS   VDD
T8   NC   NC   VSS   VDD
T9   VSS   NC
|**********************DIFF PIN*********************************************
[Diff_pin]   inv_pin   vdiff   tdelay_typ   tdelay_min   tdelay_max
   C7   B7   0.320V   0ns   NA   NA
   F3   G3   0.320V   0ns   NA   NA
   J7   K7   0.320V   0ns   NA   NA
| COMPONENT: MT41K1G4V00H (Bare Die, x4)
[Component]   MT41K1G4V00H
[Manufacturer]  Micron Technology,Inc.
[Package]
|   typ   min   max
R_pkg   0.001m   0.001m   0.001m
L_pkg   0.001nH   0.001nH   0.001nH
C_pkg   0.001pF   0.001pF   0.001pF
[Pin]   signal_name model_name   R_pin   L_pin   C_pin
1   VDD   POWER
2   DNU   NC
3   VSS   GND
4   VSSQ   GND
5   DNU   NC
6   DNU   NC
7   DNU   NC
8   VDDQ   POWER
9   DNU   NC
10   VSSQ   GND
11   DNU   NC
12   VDDQ   POWER
13   DNU   NC
14   VSSQ   GND
15   DNU   NC
16   VSSQ   GND
17   DNU   NC
18   VDDQ   POWER
19   VSS   GND
20   VDD   POWER
21   VSSQ   GND
22   DNU   NC
23   VDDQ   POWER
24   DNU   NC
25   VSSQ   GND
26   DNU   NC
27   VSSQ   GND
28   DNU   NC
29   VDDQ   POWER
30   NC   NC
31   VSSQ   GND
32   DM   DM
33   VDDQ   POWER
34   DQ0   DQ
35   VSSQ   GND
36   DQ2   DQ
37   VSSQ   GND
38   DQ3   DQ
39   VDDQ   POWER
40   DQ1   DQ
41   VSS   GND
42   VDD   POWER
43   VDDQ   POWER
44   DQS   DQS
45   VSSQ   GND
46   DQS#   DQS
47   VSSQ   GND
48   DNU   NC
49   VDDQ   POWER
50   DNU   NC
51   VSSQ   GND
52   DNU   NC
53   VDDQ   POWER
54   DNU   NC
55   VSSQ   GND
56   ZQ   NC
57   VREFDQ   POWER
58   VDD   POWER
59   VSS   GND
60   RAS   INPUT2
61   VSSDL   GND
62   VDDL   POWER
63   CLK   CLKIN
64   CLK#   CLKIN
65   CAS   INPUT2
66   CKE   INPUT1
67   ODT   INPUT1
68   A10   INPUT2
69   CS#   INPUT2
70   WE   INPUT2
71   VREFCA   POWER
72   BA0   INPUT1
73   BA2   INPUT1
74   VSS   GND
75   VDD   POWER
76   A15   INPUT2
77   BA1   INPUT1
78   A3   INPUT1
79   A12   INPUT2
80   A0   INPUT2
81   A4   INPUT1
82   A5   INPUT1
83   A1   INPUT1
84   A2   INPUT1
85   A6   INPUT1
86   A7   INPUT1
87   A11   INPUT1
88   A9   INPUT1
89   A8   INPUT1
90   RST#   RESET
91   A14   INPUT1
92   A13   INPUT1
93   DNU   NC
94   VDD   POWER
95   DNU   NC
96   VSS   GND
97   DNU   NC
|**********************DIFF PIN*********************************************
[Diff_pin]   inv_pin   vdiff   tdelay_typ   tdelay_min   tdelay_max
   44   46   0.320V   0ns   NA   NA
   63   64   0.320V   0ns   NA   NA
| COMPONENT: MT41K512M8V00H (Bare Die, x8)
[Component]   MT41K512M8V00H
[Manufacturer]  Micron Technology, Inc.
[Package]
|   typ   min   max
R_pkg   0.001m   0.001m   0.001m
L_pkg   0.001nH   0.001nH   0.001nH
C_pkg   0.001pF   0.001pF   0.001pF
[Pin]   signal_name model_name   R_pin   L_pin   C_pin
1   VDD   POWER
2   DNU   NC
3   VSS   GND
4   VSSQ   GND
5   DNU   NC
6   DNU   NC
7   DNU   NC
8   VDDQ   POWER
9   DNU   NC
10   VSSQ   GND
11   DNU   NC
12   VDDQ   POWER
13   DNU   NC
14   VSSQ   GND
15   DNU   NC
16   VSSQ   GND
17   DNU   NC
18   VDDQ   POWER
19   VSS   GND
20   VDD   POWER
21   VSSQ   GND
22   DNU   NC
23   VDDQ   POWER
24   DNU   NC
25   VSSQ   GND
26   DNU   NC
27   VSSQ   GND
28   DNU   NC
29   VDDQ   POWER
30   NF_TDQS#   NF_TDQS#
31   VSSQ   GND
32   DM_TDQS   DM_TDQS
33   VDDQ   POWER
34   DQ0   DQ
35   VSSQ   GND
36   DQ2   DQ
37   VSSQ   GND
38   DQ3   DQ
39   VDDQ   POWER
40   DQ1   DQ
41   VSS   GND
42   VDD   POWER
43   VDDQ   POWER
44   DQS   DQS
45   VSSQ   GND
46   DQS#   DQS
47   VSSQ   GND
48   DQ5   DQ
49   VDDQ   POWER
50   DQ7   DQ
51   VSSQ   GND
52   DQ6   DQ
53   VDDQ   POWER
54   DQ4   DQ
55   VSSQ   GND
56   ZQ   NC
57   VREFDQ   POWER
58   VDD   POWER
59   VSS   GND
60   RAS   INPUT2
61   VSSDL   GND
62   VDDL   POWER
63   CK   CLKIN
64   CK#   CLKIN
65   CAS   INPUT2
66   CKE   INPUT1
67   ODT   INPUT1
68   A10   INPUT2
69   CS#   INPUT2
70   WE   INPUT2
71   VREFCA   POWER
72   BA0   INPUT1
73   BA2   INPUT1
74   VSS   GND
75   VDD   POWER
76   A15   INPUT2
77   BA1   INPUT1
78   A3   INPUT1
79   A12   INPUT2
80   A0   INPUT2
81   A4   INPUT1
82   A5   INPUT1
83   A1   INPUT1
84   A2   INPUT1
85   A6   INPUT1
86   A7   INPUT1
87   A11   INPUT1
88   A9   INPUT1
89   A8   INPUT1
90   RST#   RESET
91   A14   INPUT1
92   A13   INPUT1
93   DNU   NC
94   VDD   POWER
95   DNU   NC
96   VSS   GND
97   DNU   NC
|**********************DIFF PIN*********************************************
[Diff_pin]   inv_pin   vdiff   tdelay_typ   tdelay_min   tdelay_max
   44   46   0.320V   0ns   NA   NA
   63   64   0.320V   0ns   NA   NA
| COMPONENT: MT41K256M16V00H (Bare Die, x16)
[Component]   MT41K256M16V00H
[Manufacturer]  Micron Technology, Inc.
[Package]
|   typ   min   max
R_pkg   0.001m   0.001m   0.001m
L_pkg   0.001nH   0.001nH   0.001nH
C_pkg   0.001pF   0.001pF   0.001pF
[Pin]   signal_name model_name   R_pin   L_pin   C_pin
1   VDD   POWER
2   DNU   NC
3   VSS   GND
4   VSSQ   GND
5   DNU   NC
6   DQ12   DQ
7   DNU   NC
8   VDDQ   POWER
9   DQ14   DQ
10   VSSQ   GND
11   DQ15   DQ
12   VDDQ   POWER
13   DQ13   DQ
14   VSSQ   GND
15   UDQS#   DQS
16   VSSQ   GND
17   UDQS   DQS
18   VDDQ   POWER
19   VSS   GND
20   VDD   POWER
21   VSSQ   GND
22   DQ9   DQ
23   VDDQ   POWER
24   DQ11   DQ
25   VSSQ   GND
26   DQ10   DQ
27   VSSQ   GND
28   DQ8   DQ
29   VDDQ   POWER
30   UDM   DM
31   VSSQ   GND
32   LDM   DM
33   VDDQ   POWER
34   DQ0   DQ
35   VSSQ   GND
36   DQ2   DQ
37   VSSQ   GND
38   DQ3   DQ
39   VDDQ   POWER
40   DQ1   DQ
41   VSS   GND
42   VDD   POWER
43   VDDQ   POWER
44   LDQS   DQS
45   VSSQ   GND
46   LDQS#   DQS
47   VSSQ   GND
48   DQ5   DQ
49   VDDQ   POWER
50   DQ7   DQ
51   VSSQ   GND
52   DQ6   DQ
53   VDDQ   POWER
54   DQ4   DQ
55   VSSQ   GND
56   ZQ   NC
57   VREFDQ   POWER
58   VDD   POWER
59   VSS   GND
60   RAS   INPUT2
61   VSSDL   GND
62   VDDL   POWER
63   CK   CLKIN
64   CK#   CLKIN
65   CAS   INPUT2
66   CKE   INPUT1
67   ODT   INPUT1
68   A10   INPUT2
69   CS#   INPUT2
70   WE   INPUT2
71   VREFCA   POWER
72   BA0   INPUT1
73   BA2   INPUT1
74   VSS   GND
75   VDD   POWER
76   A15   NC
77   BA1   INPUT1
78   A3   INPUT1
79   A12   INPUT2
80   A0   INPUT2
81   A4   INPUT1
82   A5   INPUT1
83   A1   INPUT1
84   A2   INPUT1
85   A6   INPUT1
86   A7   INPUT1
87   A11   INPUT1
88   A9   INPUT1
89   A8   INPUT1
90   RST#   RESET
91   A14   INPUT1
92   A13   INPUT1
93   DNU   NC
94   VDD   POWER
95   DNU   NC
96   VSS   GND
97   DNU   NC
|**********************DIFF PIN*********************************************
[Diff_pin]   inv_pin   vdiff   tdelay_typ   tdelay_min   tdelay_max
   17   15   0.320V   0ns   NA   NA
   44   46   0.320V   0ns   NA   NA
   63   64   0.320V   0ns   NA   NA
|   Model Selector
[Model Selector] DQ
DQ_34_1066   34 Ohm Data I/O with no ODT, 800/1066Mbps
DQ_40_1066   40 Ohm Data I/O with no ODT, 800/1066Mbps
DQ_IN_ODT20_1066   Data Input with 20ohm ODT, 800/1066Mbps
DQ_IN_ODT30_1066   Data Input with 30ohm ODT, 800/1066Mbps
DQ_IN_ODT40_1066   Data Input with 40ohm ODT, 800/1066Mbps
DQ_IN_ODT60_1066   Data Input with 60ohm ODT, 800/1066Mbps
DQ_IN_ODT120_1066  Data Input with 120ohm ODT, 800/1066Mbps
DQ_34_1600   34 Ohm Data I/O with no ODT, 1333/1600Mbps
DQ_40_1600   40 Ohm Data I/O with no ODT, 1333/1600Mbps
DQ_IN_ODT20_1600   Data Input with 20ohm ODT, 1333/1600Mbps
DQ_IN_ODT30_1600   Data Input with 30ohm ODT, 1333/1600Mbps
DQ_IN_ODT40_1600   Data Input with 40ohm ODT, 1333/1600Mbps
DQ_IN_ODT60_1600   Data Input with 60ohm ODT, 1333/1600Mbps
DQ_IN_ODT120_1600  Data Input with 120ohm ODT, 1333/1600Mbps
DQ_34_1866   34 Ohm Data I/O with no ODT, 1866Mbps
DQ_40_1866   40 Ohm Data I/O with no ODT, 1866Mbps
DQ_IN_ODT20_1866   Data Input with 20ohm ODT, 1866Mbps
DQ_IN_ODT30_1866   Data Input with 30ohm ODT, 1866Mbps
DQ_IN_ODT40_1866   Data Input with 40ohm ODT, 1866Mbps
DQ_IN_ODT60_1866   Data Input with 60ohm ODT, 1866Mbps
DQ_IN_ODT120_1866  Data Input with 120ohm ODT, 1866Mbps
DQ_34_2133   34 Ohm Data I/O with no ODT, 2133Mbps
DQ_40_2133   40 Ohm Data I/O with no ODT, 2133Mbps
DQ_IN_ODT20_2133   Data Input with 20ohm ODT, 2133Mbps
DQ_IN_ODT30_2133   Data Input with 30ohm ODT, 2133Mbps
DQ_IN_ODT40_2133   Data Input with 40ohm ODT, 2133Mbps
DQ_IN_ODT60_2133   Data Input with 60ohm ODT, 2133Mbps
DQ_IN_ODT120_2133  Data Input with 120ohm ODT, 2133Mbps
[Model Selector] DQS
DQS_34_1066   34 Ohm Data Strobe I/O with no ODT, 800/1066Mbps
DQS_40_1066   40 Ohm Data Strobe I/O with no ODT, 800/1066Mbps
DQS_IN_ODT20_1066  Data Strobe Input with 20ohm ODT, 800/1066Mbps
DQS_IN_ODT30_1066  Data Strobe Input with 30ohm ODT, 800/1066Mbps
DQS_IN_ODT40_1066  Data Strobe Input with 40ohm ODT, 800/1066Mbps
DQS_IN_ODT60_1066  Data Strobe Input with 60ohm ODT, 800/1066Mbps
DQS_IN_ODT120_1066 Data Strobe Input with 120ohm ODT, 800/1066Mbps
DQS_34_1600   34 Ohm Data Strobe I/O with no ODT, 1333/1600Mbps
DQS_40_1600   40 Ohm Data Strobe I/O with no ODT, 1333/1600Mbps
DQS_IN_ODT20_1600  Data Strobe Input with 20ohm ODT, 1333/1600Mbps
DQS_IN_ODT30_1600  Data Strobe Input with 30ohm ODT, 1333/1600Mbps
DQS_IN_ODT40_1600  Data Strobe Input with 40ohm ODT, 1333/1600Mbps
DQS_IN_ODT60_1600  Data Strobe Input with 60ohm ODT, 1333/1600Mbps
DQS_IN_ODT120_1600 Data Strobe Input with 120ohm ODT, 1333/1600Mbps
DQS_34_1866   34 Ohm Data Strobe I/O with no ODT, 1866Mbps
DQS_40_1866   40 Ohm Data Strobe I/O with no ODT, 1866Mbps
DQS_IN_ODT20_1866  Data Strobe Input with 20ohm ODT, 1866Mbps
DQS_IN_ODT30_1866  Data Strobe Input with 30ohm ODT, 1866Mbps
DQS_IN_ODT40_1866  Data Strobe Input with 40ohm ODT, 1866Mbps
DQS_IN_ODT60_1866  Data Strobe Input with 60ohm ODT, 1866Mbps
DQS_IN_ODT120_1866 Data Strobe Input with 120ohm ODT, 1866Mbps
DQS_34_2133   34 Ohm Data Strobe I/O with no ODT, 2133Mbps
DQS_40_2133   40 Ohm Data Strobe I/O with no ODT, 2133Mbps
DQS_IN_ODT20_2133  Data Strobe Input with 20ohm ODT, 2133Mbps
DQS_IN_ODT30_2133  Data Strobe Input with 30ohm ODT, 2133Mbps
DQS_IN_ODT40_2133  Data Strobe Input with 40ohm ODT, 2133Mbps
DQS_IN_ODT60_2133  Data Strobe Input with 60ohm ODT, 2133Mbps
DQS_IN_ODT120_2133 Data Strobe Input with 120ohm ODT, 2133Mbps
[Model Selector] DM
DM_INPUT_1066   DM Input Model with no ODT, 800/1066Mbps
DM_ODT20_1066   DM Input Model with 20ohm ODT, 800/1066Mbps
DM_ODT30_1066   DM Input Model with 30ohm ODT, 800/1066Mbps
DM_ODT40_1066   DM Input Model with 40ohm ODT, 800/1066Mbps
DM_ODT60_1066   DM Input Model with 60ohm ODT, 800/1066Mbps
DM_ODT120_1066   DM Input Model with 120ohm ODT, 800/1066Mbps
DM_INPUT_1600   DM Input Model with no ODT, 1333/1600Mbps
DM_ODT20_1600   DM Input Model with 20ohm ODT, 1333/1600Mbps
DM_ODT30_1600   DM Input Model with 30ohm ODT, 1333/1600Mbps
DM_ODT40_1600   DM Input Model with 40ohm ODT, 1333/1600Mbps
DM_ODT60_1600   DM Input Model with 60ohm ODT, 1333/1600Mbps
DM_ODT120_1600   DM Input Model with 120ohm ODT, 1333/1600Mbps
DM_INPUT_1866   DM Input Model with no ODT, 1866Mbps
DM_ODT20_1866   DM Input Model with 20ohm ODT, 1866Mbps
DM_ODT30_1866   DM Input Model with 30ohm ODT, 1866Mbps
DM_ODT40_1866   DM Input Model with 40ohm ODT, 1866Mbps
DM_ODT60_1866   DM Input Model with 60ohm ODT, 1866Mbps
DM_ODT120_1866   DM Input Model with 120ohm ODT, 1866Mbps
DM_INPUT_2133   DM Input Model with no ODT, 2133Mbps
DM_ODT20_2133   DM Input Model with 20ohm ODT, 2133Mbps
DM_ODT30_2133   DM Input Model with 30ohm ODT, 2133Mbps
DM_ODT40_2133   DM Input Model with 40ohm ODT, 2133Mbps
DM_ODT60_2133   DM Input Model with 60ohm ODT, 2133Mbps
DM_ODT120_2133   DM Input Model with 120ohm ODT, 2133Mbps
[Model Selector] DM_TDQS
DM_INPUT_1066   DM Input Model with no ODT, 800/1066Mbps
DM_ODT20_1066   DM Input Model with 20ohm ODT, 800/1066Mbps
DM_ODT30_1066   DM Input Model with 30ohm ODT, 800/1066Mbps
DM_ODT40_1066   DM Input Model with 40ohm ODT, 800/1066Mbps
DM_ODT60_1066   DM Input Model with 60ohm ODT, 800/1066Mbps
DM_ODT120_1066   DM Input Model with 120ohm ODT, 800/1066Mbps
DM_INPUT_1600   DM Input Model with no ODT, 1333/1600Mbps
DM_ODT20_1600   DM Input Model with 20ohm ODT, 1333/1600Mbps
DM_ODT30_1600   DM Input Model with 30ohm ODT, 1333/1600Mbps
DM_ODT40_1600   DM Input Model with 40ohm ODT, 1333/1600Mbps
DM_ODT60_1600   DM Input Model with 60ohm ODT, 1333/1600Mbps
DM_ODT120_1600   DM Input Model with 120ohm ODT, 1333/1600Mbps
DM_INPUT_1866   DM Input Model with no ODT, 1866Mbps
DM_ODT20_1866   DM Input Model with 20ohm ODT, 1866Mbps
DM_ODT30_1866   DM Input Model with 30ohm ODT, 1866Mbps
DM_ODT40_1866   DM Input Model with 40ohm ODT, 1866Mbps
DM_ODT60_1866   DM Input Model with 60ohm ODT, 1866Mbps
DM_ODT120_1866   DM Input Model with 120ohm ODT, 1866Mbps
DM_INPUT_2133   DM Input Model with no ODT, 2133Mbps
DM_ODT20_2133   DM Input Model with 20ohm ODT, 2133Mbps
DM_ODT30_2133   DM Input Model with 30ohm ODT, 2133Mbps
DM_ODT40_2133   DM Input Model with 40ohm ODT, 2133Mbps
DM_ODT60_2133   DM Input Model with 60ohm ODT, 2133Mbps
DM_ODT120_2133   DM Input Model with 120ohm ODT, 2133Mbps
TDQS_ODT20_1066   TDQS Terminator Model with 20ohm ODT, 800/1066Mbps
TDQS_ODT30_1066   TDQS Terminator Model with 30ohm ODT, 800/1066Mbps
TDQS_ODT40_1066   TDQS Terminator Model with 40ohm ODT, 800/1066Mbps
TDQS_ODT60_1066   TDQS Terminator Model with 60ohm ODT, 800/1066Mbps
TDQS_ODT120_1066   TDQS Terminator Model with 120ohm ODT, 800/1066Mbps
TDQS_ODT20_1600   TDQS Terminator Model with 20ohm ODT, 1333/1600Mbps
TDQS_ODT30_1600   TDQS Terminator Model with 30ohm ODT, 1333/1600Mbps
TDQS_ODT40_1600   TDQS Terminator Model with 40ohm ODT, 1333/1600Mbps
TDQS_ODT60_1600   TDQS Terminator Model with 60ohm ODT, 1333/1600Mbps
TDQS_ODT120_1600   TDQS Terminator Model with 120ohm ODT, 1333/1600Mbps
TDQS_ODT20_1866   TDQS Terminator Model with 20ohm ODT, 1866Mbps
TDQS_ODT30_1866   TDQS Terminator Model with 30ohm ODT, 1866Mbps
TDQS_ODT40_1866   TDQS Terminator Model with 40ohm ODT, 1866Mbps
TDQS_ODT60_1866   TDQS Terminator Model with 60ohm ODT, 1866Mbps
TDQS_ODT120_1866   TDQS Terminator Model with 120ohm ODT, 1866Mbps
TDQS_ODT20_2133   TDQS Terminator Model with 20ohm ODT, 2133Mbps
TDQS_ODT30_2133   TDQS Terminator Model with 30ohm ODT, 2133Mbps
TDQS_ODT40_2133   TDQS Terminator Model with 40ohm ODT, 2133Mbps
TDQS_ODT60_2133   TDQS Terminator Model with 60ohm ODT, 2133Mbps
TDQS_ODT120_2133   TDQS Terminator Model with 120ohm ODT, 2133Mbps
[Model Selector] NF_TDQS#
NF_INPUT   Non-Functioning Terminator Model
TDQS_ODT20_1066   TDQS Terminator Model with 20ohm ODT, 800/1066Mbps
TDQS_ODT30_1066   TDQS Terminator Model with 30ohm ODT, 800/1066Mbps
TDQS_ODT40_1066   TDQS Terminator Model with 40ohm ODT, 800/1066Mbps
TDQS_ODT60_1066   TDQS Terminator Model with 60ohm ODT, 800/1066Mbps
TDQS_ODT120_1066   TDQS Terminator Model with 120ohm ODT, 800/1066Mbps
TDQS_ODT20_1600   TDQS Terminator Model with 20ohm ODT, 1333/1600Mbps
TDQS_ODT30_1600   TDQS Terminator Model with 30ohm ODT, 1333/1600Mbps
TDQS_ODT40_1600   TDQS Terminator Model with 40ohm ODT, 1333/1600Mbps
TDQS_ODT60_1600   TDQS Terminator Model with 60ohm ODT, 1333/1600Mbps
TDQS_ODT120_1600   TDQS Terminator Model with 120ohm ODT, 1333/1600Mbps
TDQS_ODT20_1866   TDQS Terminator Model with 20ohm ODT, 1866Mbps
TDQS_ODT30_1866   TDQS Terminator Model with 30ohm ODT, 1866Mbps
TDQS_ODT40_1866   TDQS Terminator Model with 40ohm ODT, 1866Mbps
TDQS_ODT60_1866   TDQS Terminator Model with 60ohm ODT, 1866Mbps
TDQS_ODT120_1866   TDQS Terminator Model with 120ohm ODT, 1866Mbps
TDQS_ODT20_2133   TDQS Terminator Model with 20ohm ODT, 2133Mbps
TDQS_ODT30_2133   TDQS Terminator Model with 30ohm ODT, 2133Mbps
TDQS_ODT40_2133   TDQS Terminator Model with 40ohm ODT, 2133Mbps
TDQS_ODT60_2133   TDQS Terminator Model with 60ohm ODT, 2133Mbps
TDQS_ODT120_2133   TDQS Terminator Model with 120ohm ODT, 2133Mbps
[Model Selector] INPUT1
INPUT1_1066   Add/Cmd/Ctrl Input Model, 800/1066Mbps
INPUT1_1600   Add/Cmd/Ctrl Input Model, 1333/1600Mbps
INPUT1_1866   Add/Cmd/Ctrl Input Model, 1866Mbps
INPUT1_2133   Add/Cmd/Ctrl Input Model, 2133Mbps
[Model Selector] INPUT2
INPUT2_1066   Add/Cmd/Ctrl Input Model, 800/1066Mbps
INPUT2_1600   Add/Cmd/Ctrl Input Model, 1333/1600Mbps
INPUT2_1866   Add/Cmd/Ctrl Input Model, 1866Mbps
INPUT2_2133   Add/Cmd/Ctrl Input Model, 2133Mbps
[Model Selector] CLKIN
CLKIN_1066   Clock Input Model, 800/1066Mbps
CLKIN_1600   Clock Input Model, 1333/1600Mbps
CLKIN_1866   Clock Input Model, 1866Mbps
CLKIN_2133   Clock Input Model, 2133Mbps
| Sparse Matrix Package Model for v00h_78ball_pkg (x4/x8)
[Define Package Model] v00h_78ball_pkg
[Manufacturer] Micron Technology, Inc.
[OEM] Micron Technology, Inc.
[Description] V00H package model for 8mm X 10.5mm 78-Ball FBGA
[Number of Pins] 51
[Pin Numbers]
A1  | VSS_SUBNET_000
A2  | VCC_SUBNET_000
A7  | TDQS#
B3  | DQ0
B7  | DM
B9  | VDDQ_SUBNET_001
C1  | VDDQ_SUBNET_000
C2  | DQ2
C3  | DQS
C7  | DQ1
C8  | DQ3
D2  | DQ6
D3  | DQS#
D7  | VCC_SUBNET_001
E1  | VREFDQ
E3  | DQ4
E7  | DQ7
E8  | DQ5
F2  | VSSDL
F3  | RAS#
F7  | CLK
F8  | VSS_SUBNET_001
G1  | ODT
G2  | VCCDLL
G3  | CAS#
G7  | CLK#
G9  | CKE
H2  | CS#
H3  | WE#
H7  | A10
H8  | ZQ
J2  | BA0
J3  | BA2
J7  | A15
J8  | VREFCA
K2  | A3
K3  | A0
K7  | A12
K8  | BA1
L2  | A5
L3  | A2
L7  | A1
L8  | A4
M2  | A7
M3  | A9
M7  | A11
M8  | A6
N2  | RST#
N3  | A13
N7  | A14
N8  | A8
[Model Data]
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[End Model Data]
[End Package Model]
| Sparse Matrix Package Model for v00h_96ball_pkg (x16)
[Define Package Model] v00h_96ball_pkg
[Manufacturer] Micron Technology, Inc.
[OEM] Micron Technology, Inc.
[Description] V00H package model for 8mm X 14mm 96-Ball FBGA
[Number of Pins] 60
[Pin Numbers]
A1  | VDDQ
A2  | DQ13
A3  | DQ15
A7  | DQ12
B2  | VDD_SUBNET_001
B7  | UDQS#
B8  | DQ14
C2  | DQ11
C3  | DQ9
C7  | UDQS
C8  | DQ10
D3  | TDQS#
D7  | DQ8
D9  | VDD_SUBNET_000
E3  | DQ0
E7  | DM
F2  | DQ2
F3  | DQS
F7  | DQ1
F8  | DQ3
G2  | DQ6
G3  | DQS#
G7  | VDD_SUBNET_002
H1  | VREFDQ
H3  | DQ4
H7  | DQ7
H8  | DQ5
J2  | VSSL
J3  | RAS#
J7  | CK
K1  | ODT
K2  | VCCL
K3  | CAS#
K7  | CK#
K9  | CKE
L2  | CS#
L3  | WE#
L7  | A10
L8  | ZQ
M2  | BA0
M3  | BA2
M7  | A15
M8  | VREFCA
N2  | A3
N3  | A0
N7  | A12
N8  | BA1
P2  | A5
P3  | A2
P7  | A1
P8  | A4
R2  | A7
R3  | A9
R7  | A11
R8  | A6
T2  | RST#
T3  | A13
T7  | A14
T8  | A8
T9  | VSS
[Model Data]
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[End Model Data]
[End Package Model]
| Models and submodels in the file (134): DQ_34_1066 (I/O), DQ_40_1066 (I/O), DQ_IN_ODT20_1066 (Input), DQ_IN_ODT30_1066 (Input), DQ_IN_ODT40_1066 (Input), DQ_IN_ODT60_1066 (Input), DQ_IN_ODT120_1066 (Input), DQ_34_1600 (I/O), DQ_40_1600 (I/O), DQ_IN_ODT20_1600 (Input), DQ_IN_ODT30_1600 (Input), DQ_IN_ODT40_1600 (Input), DQ_IN_ODT60_1600 (Input), DQ_IN_ODT120_1600 (Input), DQ_34_1866 (I/O), DQ_40_1866 (I/O), DQ_IN_ODT20_1866 (Input), DQ_IN_ODT30_1866 (Input), DQ_IN_ODT40_1866 (Input), DQ_IN_ODT60_1866 (Input), DQ_IN_ODT120_1866 (Input), DQ_34_2133 (I/O), DQ_40_2133 (I/O), DQ_IN_ODT20_2133 (Input), DQ_IN_ODT30_2133 (Input), DQ_IN_ODT40_2133 (Input), DQ_IN_ODT60_2133 (Input), DQ_IN_ODT120_2133 (Input), DQS_34_1066 (I/O), DQS_40_1066 (I/O), DQS_IN_ODT20_1066 (Input), DQS_IN_ODT30_1066 (Input), DQS_IN_ODT40_1066 (Input), DQS_IN_ODT60_1066 (Input), DQS_IN_ODT120_1066 (Input), DQS_34_1600 (I/O), DQS_40_1600 (I/O), DQS_IN_ODT20_1600 (Input), DQS_IN_ODT30_1600 (Input), DQS_IN_ODT40_1600 (Input), DQS_IN_ODT60_1600 (Input), DQS_IN_ODT120_1600 (Input), DQS_34_1866 (I/O), DQS_40_1866 (I/O), DQS_IN_ODT20_1866 (Input), DQS_IN_ODT30_1866 (Input), DQS_IN_ODT40_1866 (Input), DQS_IN_ODT60_1866 (Input), DQS_IN_ODT120_1866 (Input), DQS_34_2133 (I/O), DQS_40_2133 (I/O), DQS_IN_ODT20_2133 (Input), DQS_IN_ODT30_2133 (Input), DQS_IN_ODT40_2133 (Input), DQS_IN_ODT60_2133 (Input), DQS_IN_ODT120_2133 (Input), DM_INPUT_1066 (Input), DM_ODT20_1066 (Input), DM_ODT30_1066 (Input), DM_ODT40_1066 (Input), DM_ODT60_1066 (Input), DM_ODT120_1066 (Input), DM_INPUT_1600 (Input), DM_ODT20_1600 (Input), DM_ODT30_1600 (Input), DM_ODT40_1600 (Input), DM_ODT60_1600 (Input), DM_ODT120_1600 (Input), DM_INPUT_1866 (Input), DM_ODT20_1866 (Input), DM_ODT30_1866 (Input), DM_ODT40_1866 (Input), DM_ODT60_1866 (Input), DM_ODT120_1866 (Input), DM_INPUT_2133 (Input), DM_ODT20_2133 (Input), DM_ODT30_2133 (Input), DM_ODT40_2133 (Input), DM_ODT60_2133 (Input), DM_ODT120_2133 (Input)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
